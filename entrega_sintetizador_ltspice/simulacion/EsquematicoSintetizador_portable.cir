* Sintetizador de formas de onda - simulacion portable LTspice
* Puede correrse desde esta carpeta porque los modelos estan en simulacion/modelos.
XU1 0 VC555 SC +15V N012 VC555 NC_01 +15V NE555 ;??pnba GND)TRIG)OUT)RST)CV)THRS)DIS)Vcc
R1 SC VC555 31.45k
C1 VC555 0 10nF
V1 +15V 0 15
V2 -15V 0 -15
C2 0 N012 10nF
C3 N004 SC 1nF
R2 N004 0 10k
D1 N004 RST_DS 1N4148
R3 RST_DS 0 47k
R5 RST_DS N005 3.3k
Q1 DS N005 0 0 2N3904
C4 DS 0 10n
R6 +15V DS 53.6k
R4 N005 0 47k
R7 N016 SC 47k
R8 N016 0 100k
Q2 N014 N016 0 0 2N3904
R9 +15V N014 10k
C5 N015 N014 1nF
R10 N015 0 10k
D2 N015 RST_DS 1N4148
R11 N001 SC_D2 27.4k
R12 N001 -15V 168k
XU3 0 N001 +15V -15V TRI LF353/NS ;??pnba In+)In-)V+)V-)OUT
C6 TRI N001 10n
R13 N001 TRI 1Meg
XU2 0 SC N013 0 SC_D2 N013 VDD 0 CD4013B VDD=5 SPEED=1.0 TRIPDT=5e-9 ;??pnba S)C1)1D)R)Q)_Q
R14 N008 TRI 498K
R15 N008 0 100k
R16 N009 N008 30.7k
C7 N009 0 10n
XU6 N009 FILT_BUF +15V -15V FILT_BUF LF353/NS ; buffer despues de R16-C7
R17 N010 FILT_BUF 16.1k
C8 N010 SK1_SAL 10n
R18 N011 N010 16.1k
XU5 N011 N003 +15V -15V SK1_SAL LF353/NS ;??pnba In+)In-)V+)V-)OUT
R19 SK1_SAL N003 11.5k
R20 N003 0 10k
C9 N006 SEN 10n
R21 N007 N006 10.9k
XU4 N007 N002 +15V -15V SEN LF353/NS ;??pnba In+)In-)V+)V-)OUT
R22 SEN N002 17.8k
R23 0 N002 10k
R24 N006 SK1_SAL 10.9k
C10 N011 0 10n
C11 N007 0 10n
.model D D
.lib standard.dio
.model NPN NPN
.model PNP PNP
.lib standard.bjt
* ETAPA 1 OSCILADOR CUADRADA
.options method=gear reltol=0.003 abstol=1n vntol=1u chgtol=1p
.tran 0 120m 0 1u
.save V(SC) V(VC555) V(RST_DS) V(DS) V(SC_D2) V(TRI) V(SEN)
* ============================================================
* RESULTADOS FINALES PARA EL SPICE OUTPUT LOG
* Solo se dejan los datos que se usan en el informe del proyecto.
* ============================================================
* -------- ETAPA 1: NE555 / CUADRADA SC --------
.meas tran Z11_SC_PERIODO_S TRIG V(SC) VAL=7.5 TD=4m RISE=1 TARG V(SC) VAL=7.5 TD=4m RISE=2
.meas tran Z12_SC_FRECUENCIA_HZ PARAM='1/Z11_SC_PERIODO_S'
.meas tran Z13_SC_T_ALTO_S TRIG V(SC) VAL=7.5 TD=4m RISE=1 TARG V(SC) VAL=7.5 TD=4m FALL=2
.meas tran Z14_SC_CICLO_TRABAJO_PCT PARAM='100*Z13_SC_T_ALTO_S/Z11_SC_PERIODO_S'
.meas tran Z15_SC_ERROR_PCT PARAM='100*(Z12_SC_FRECUENCIA_HZ-2290)/2290'
.meas tran Z16_SC_VPP_V PP V(SC) FROM=4m TO=8m
.meas tran Z17_VC555_VPP_V PP V(VC555) FROM=4m TO=8m
* -------- ETAPA 2: DIENTE DE SIERRA DS --------
.meas tran Z21_DS_DOS_PERIODOS_S TRIG V(DS) VAL=2.5 TD=4m RISE=1 TARG V(DS) VAL=2.5 TD=4m RISE=3
.meas tran Z22_DS_FRECUENCIA_HZ PARAM='2/Z21_DS_DOS_PERIODOS_S'
.meas tran Z23_DS_ERROR_PCT PARAM='100*(Z22_DS_FRECUENCIA_HZ-4580)/4580'
.meas tran Z24_DS_VPP_V PP V(DS) FROM=4m TO=8m
.meas tran Z25_RST_DS_VMAX_V MAX V(RST_DS) FROM=4m TO=8m
* -------- ETAPA 3A: DIVISOR POR 2 SC_D2 --------
.meas tran Z31_SC_D2_PERIODO_S TRIG V(SC_D2) VAL=2.45 TD=4m CROSS=1 TARG V(SC_D2) VAL=2.45 TD=4m CROSS=3
.meas tran Z32_SC_D2_FRECUENCIA_HZ PARAM='1/Z31_SC_D2_PERIODO_S'
.meas tran Z33_SC_D2_ERROR_PCT PARAM='100*(Z32_SC_D2_FRECUENCIA_HZ-1145)/1145'
.meas tran Z34_SC_D2_VPP_V PP V(SC_D2) FROM=4m TO=8m
* -------- ETAPA 3B: INTEGRADOR TRIANGULAR TRI --------
.meas tran Z41_TRI_NIVEL_MEDIO_V AVG V(TRI) FROM=50m TO=70m
.meas tran Z42_TRI_PERIODO_DIRECTO_S TRIG V(TRI) VAL='Z41_TRI_NIVEL_MEDIO_V' TD=50m CROSS=1 TARG V(TRI) VAL='Z41_TRI_NIVEL_MEDIO_V' TD=50m CROSS=3
.meas tran Z43_TRI_FRECUENCIA_DIRECTA_HZ PARAM='1/Z42_TRI_PERIODO_DIRECTO_S'
.meas tran Z44_TRI_ERROR_DIRECTO_PCT PARAM='100*(Z43_TRI_FRECUENCIA_DIRECTA_HZ-1145)/1145'
.meas tran Z45_TRI_FRECUENCIA_REF_HZ PARAM='Z32_SC_D2_FRECUENCIA_HZ'
.meas tran Z46_TRI_ERROR_REF_PCT PARAM='100*(Z45_TRI_FRECUENCIA_REF_HZ-1145)/1145'
.meas tran Z47_TRI_VPP_V PP V(TRI) FROM=50m TO=70m
* -------- ETAPA 4: FILTRO / SENOIDAL SEN --------
.meas tran Z51_SEN_NIVEL_MEDIO_V AVG V(SEN) FROM=100m TO=120m
.meas tran Z52_SEN_DIEZ_PERIODOS_S TRIG V(SEN) VAL='Z51_SEN_NIVEL_MEDIO_V' TD=100m RISE=1 TARG V(SEN) VAL='Z51_SEN_NIVEL_MEDIO_V' TD=100m RISE=11
.meas tran Z53_SEN_FRECUENCIA_HZ PARAM='10/Z52_SEN_DIEZ_PERIODOS_S'
.meas tran Z54_SEN_ERROR_PCT PARAM='100*(Z53_SEN_FRECUENCIA_HZ-1145)/1145'
.meas tran Z55_SEN_VPP_V PP V(SEN) FROM=100m TO=120m
.meas tran Z56_GANANCIA_FILTRO_VV PARAM='Z55_SEN_VPP_V/Z47_TRI_VPP_V'
* ETAPA 2 DIENTE DE SIERRA POSITIVO
* ETAPA 3 TRIANGULAR
* ETAPA 4 SENOIDAL ORDEN 5 CHEBYSHEV
.lib modelos/CD4000.lib
.lib modelos/LF353.mod
.lib modelos/NE555.sub
.backanno
.end
