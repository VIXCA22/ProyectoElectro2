* IE0413 Electronica II - Bode del filtro pasabajas de orden 5 con LF353
* Simulacion AC separada del sintetizador transitorio.
* Para Z=9 se usa respuesta Chebyshev tipo I de 0.5 dB.
* Vin tiene AC 1 V, por lo que V(out) equivale directamente a H(jw).

.include "modelos/LF353.mod"

.param X=2
.param Y=2
.param Z=9
.param f0={1k*(X+Y/10+Z/100)}
.param ftri={f0/2}
.param fc={1.25*ftri}
.param resp={if(Z<4,1,if(Z<7,2,3))}
.param Cf=10n
.param p1mul={if(resp==1,1.5023162714,if(resp==2,1,0.3623196242))}
.param s1mul={if(resp==1,1.5563471223,if(resp==2,1,0.6904831735))}
.param q1={if(resp==1,0.5635356209,if(resp==2,0.6180339887,1.1778055654))}
.param s2mul={if(resp==1,1.7553777766,if(resp==2,1,1.0177347431))}
.param q2={if(resp==1,0.9164773739,if(resp==2,1.6180339887,4.5449633297))}
.param k1={3-1/q1}
.param k2={3-1/q2}
.param Rlp1={1/(2*pi*fc*p1mul*Cf)}
.param Rsk1={1/(2*pi*fc*s1mul*Cf)}
.param Rsk2={1/(2*pi*fc*s2mul*Cf)}
.param RattBot=100k
.param RattTop={RattBot*(k1*k2-1)}

VCC Vp 0 15
VEE Vm 0 -15
Vin in 0 AC 1

Ratt1 in filt_in {RattTop}
Ratt2 filt_in 0 {RattBot}
Rfo filt_in nfo {Rlp1}
Cfo nfo 0 {Cf}
XFOBUF nfo fo Vp Vm fo LF353/NS
XSK1 fo sk1 Vp Vm SKLP PARAMS: RVAL={Rsk1} CVAL={Cf} KVAL={k1}
XSK2 sk1 out Vp Vm SKLP PARAMS: RVAL={Rsk2} CVAL={Cf} KVAL={k2}

.subckt SKLP IN OUT VP VM PARAMS: RVAL=10k CVAL=10n KVAL=1.586 RGAIN=10k
R1 IN n1 {RVAL}
R2 n1 n2 {RVAL}
C1 n1 OUT {CVAL}
C2 n2 0 {CVAL}
Rg ninv 0 {RGAIN}
Rf OUT ninv {(KVAL-1)*RGAIN}
XU n2 ninv VP VM OUT LF353/NS
.ends SKLP

.options plotwinsize=0 reltol=0.001 abstol=1n
.save V(in) V(filt_in) V(fo) V(sk1) V(out)
.ac dec 300 {ftri/10} {20*f0}
.meas ac BODE_GAN_1145 FIND mag(V(out)/V(in)) AT={ftri}
.meas ac BODE_GAN_3435 FIND mag(V(out)/V(in)) AT={3*ftri}
* fc = 1431.25 Hz para X=2, Y=2, Z=9.

.end
