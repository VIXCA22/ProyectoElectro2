* IE0413 Electronica II - Generador de diente de sierra positivo a 2f0
* Entrada cuadrada equivalente y etapa de reset con detector de flancos.

.include "lf353.mod"

.param X=2
.param Y=2
.param Z=9
.param f0={1k*(X+Y/10+Z/100)}
.param tr={1/(500*f0)}
.param Csaw=10n
.param VsawPk=5
.param Isaw={Csaw*VsawPk*2*f0}

VCC Vp 0 15
VEE Vm 0 -15
Vsq sq 0 PULSE(-5 5 0 {tr} {tr} {1/(2*f0)-tr} {1/f0})

RinvIn sq ninv 10k
RinvFb sq_inv ninv 10k
XINV 0 ninv Vp Vm sq_inv LF353/NS

Cedge1 sq edge1 220p
Redge1 edge1 0 10k
Dedge1 edge1 reset D4148
Cedge2 sq_inv edge2 220p
Redge2 edge2 0 10k
Dedge2 edge2 reset D4148
Rreset reset 0 4.7k
DresetClamp 0 reset D4148
RbReset reset breset 3.3k
RbeReset breset 0 47k
Qreset saw breset 0 Q2N3904
Icharge 0 saw {Isaw}
Csaw1 saw 0 {Csaw} ic=0

.model D4148 D(Is=2.52n Rs=0.568 N=1.752 Cjo=2p Tt=4n)
.model Q2N3904 NPN(Is=6.734f Bf=200 Vaf=74.03 Cjc=3.638p Cje=4.493p Tf=301.2p Tr=239.5n)

.options plotwinsize=0 reltol=0.001 abstol=1n
.save V(sq) V(saw) V(reset)
.tran 0 {8/f0} 0 {1/(500*f0)}
.meas tran T_saw TRIG V(saw) VAL={VsawPk/2} RISE=5 TARG V(saw) VAL={VsawPk/2} RISE=6
.meas tran f_saw PARAM 1/T_saw

.end
